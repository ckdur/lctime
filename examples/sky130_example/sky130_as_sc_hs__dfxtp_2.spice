* NGSPICE file created from sky130_as_sc_hs__dfxtp_2.ext - technology: sky130A

.subckt sky130_as_sc_hs__dfxtp_2 VNB VPB VPWR VGND CLK Q D
R1122 VPB VPWR 0
R1111 VNB VGND 0
X0 a_614_412# a_28_331# a_496_412# VPB.t11 sky130_fd_pr__pfet_01v8 ad=0.1625 pd=1.17 as=0.0924 ps=0.86 w=0.42 l=0.15
X1 VPWR.t7 CLK.t0 a_28_331# VPB.t5 sky130_fd_pr__pfet_01v8 ad=0.11755 pd=1.11 as=0.22688 ps=2.2 w=0.825 l=0.15
X2 a_398_49# D.t0 VPWR.t0 VPB.t0 sky130_fd_pr__pfet_01v8 ad=0.0864 pd=0.88 as=0.1512 ps=1.64 w=0.54 l=0.15
X3 Q.t3 a_1250_23# VGND.t2 VNB.t6 sky130_fd_pr__nfet_01v8_lvt ad=0.0903 pd=0.925 as=0.17093 ps=1.82 w=0.645 l=0.15
X4 a_754_23# a_496_412# VGND.t8 VNB.t12 sky130_fd_pr__nfet_01v8_lvt ad=0.09615 pd=0.895 as=0.08412 ps=0.845 w=0.495 l=0.15
X5 VGND.t4 a_1250_23# a_1106_49# VNB.t5 sky130_fd_pr__nfet_01v8_lvt ad=0.0855 pd=0.835 as=0.16395 ps=1.195 w=0.475 l=0.15
X6 a_200_49# a_28_331# VPWR.t6 VPB.t10 sky130_fd_pr__pfet_01v8 ad=0.23925 pd=2.23 as=0.11755 ps=1.11 w=0.825 l=0.15
X7 a_496_412# a_28_331# a_398_49# VNB.t9 sky130_fd_pr__nfet_01v8_lvt ad=0.09345 pd=0.865 as=0.09413 ps=0.925 w=0.445 l=0.15
X8 a_496_412# a_200_49# a_398_49# VPB.t3 sky130_fd_pr__pfet_01v8 ad=0.0924 pd=0.86 as=0.0864 ps=0.88 w=0.42 l=0.15
X9 a_754_23# a_496_412# VPWR.t8 VPB.t12 sky130_fd_pr__pfet_01v8 ad=0.08885 pd=0.86 as=0.08225 ps=0.82 w=0.47 l=0.15
X10 a_1110_410# a_200_49# a_992_410# VPB.t2 sky130_fd_pr__pfet_01v8 ad=0.1629 pd=1.17 as=0.0946 ps=0.87 w=0.43 l=0.15
X11 VGND.t3 a_1250_23# Q.t2 VNB.t4 sky130_fd_pr__nfet_01v8_lvt ad=0.17077 pd=1.82 as=0.0903 ps=0.925 w=0.645 l=0.15
X12 VPWR.t5 a_1250_23# Q.t1 VPB.t8 sky130_fd_pr__pfet_01v8 ad=0.26235 pd=2.51 as=0.1386 ps=1.27 w=0.99 l=0.15
X13 a_992_410# a_28_331# a_754_23# VPB.t9 sky130_fd_pr__pfet_01v8 ad=0.0946 pd=0.87 as=0.08885 ps=0.86 w=0.43 l=0.15
X14 VGND.t0 a_754_23# a_612_49# VNB.t0 sky130_fd_pr__nfet_01v8_lvt ad=0.08412 pd=0.845 as=0.15798 ps=1.155 w=0.445 l=0.15
X15 a_200_49# a_28_331# VGND.t5 VNB.t8 sky130_fd_pr__nfet_01v8_lvt ad=0.16385 pd=1.71 as=0.0805 ps=0.85 w=0.565 l=0.15
X16 VPWR.t4 a_1250_23# a_1110_410# VPB.t7 sky130_fd_pr__pfet_01v8 ad=0.0846 pd=0.83 as=0.1629 ps=1.17 w=0.47 l=0.15
X17 a_398_49# D.t1 VGND.t6 VNB.t10 sky130_fd_pr__nfet_01v8_lvt ad=0.09413 pd=0.925 as=0.161 ps=1.71 w=0.575 l=0.15
X18 a_1250_23# a_992_410# VPWR.t2 VPB.t4 sky130_fd_pr__pfet_01v8 ad=0.12455 pd=1.47 as=0.0846 ps=0.83 w=0.47 l=0.15
X19 a_612_49# a_200_49# a_496_412# VNB.t2 sky130_fd_pr__nfet_01v8_lvt ad=0.15798 pd=1.155 as=0.09345 ps=0.865 w=0.445 l=0.15
X20 VPWR.t1 a_754_23# a_614_412# VPB.t1 sky130_fd_pr__pfet_01v8 ad=0.08225 pd=0.82 as=0.1625 ps=1.17 w=0.47 l=0.15
X21 a_1106_49# a_28_331# a_992_410# VNB.t7 sky130_fd_pr__nfet_01v8_lvt ad=0.16395 pd=1.195 as=0.09122 ps=0.855 w=0.445 l=0.15
X22 a_1250_23# a_992_410# VGND.t1 VNB.t3 sky130_fd_pr__nfet_01v8_lvt ad=0.12573 pd=1.48 as=0.0855 ps=0.835 w=0.475 l=0.15
X23 VGND.t7 CLK.t1 a_28_331# VNB.t11 sky130_fd_pr__nfet_01v8_lvt ad=0.0805 pd=0.85 as=0.14973 ps=1.66 w=0.565 l=0.15
X24 Q.t0 a_1250_23# VPWR.t3 VPB.t6 sky130_fd_pr__pfet_01v8 ad=0.1386 pd=1.27 as=0.26235 ps=2.51 w=0.99 l=0.15
X25 a_992_410# a_200_49# a_754_23# VNB.t1 sky130_fd_pr__nfet_01v8_lvt ad=0.09122 pd=0.855 as=0.09615 ps=0.895 w=0.445 l=0.15
R0 VPB.t10 VPB.t0 587.812
R1 VPB.t4 VPB.t6 564.062
R2 VPB.t2 VPB.t7 504.688
R3 VPB.t11 VPB.t1 504.688
R4 VPB.t9 VPB.t2 350.312
R5 VPB.t3 VPB.t11 350.312
R6 VPB.t12 VPB.t9 320.625
R7 VPB.t7 VPB.t4 302.812
R8 VPB.t1 VPB.t12 296.875
R9 VPB.t0 VPB.t3 290.938
R10 VPB.t5 VPB.t10 258.281
R11 VPB.t6 VPB.t8 255.312
R12 VPB VPB.t5 154.375
R13 CLK.n0 CLK.t1 222.851
R14 CLK.n0 CLK.t0 201.19
R15 CLK CLK.n0 156.684
R16 VPWR.n33 VPWR.t0 663.499
R17 VPWR.n11 VPWR.t3 647.87
R18 VPWR.n1 VPWR.n0 610.225
R19 VPWR.n6 VPWR.n5 609.847
R20 VPWR.n16 VPWR.n10 609.847
R21 VPWR.n12 VPWR.t5 282.272
R22 VPWR.n5 VPWR.t8 81.7345
R23 VPWR.n10 VPWR.t4 81.7345
R24 VPWR.n10 VPWR.t2 69.1601
R25 VPWR.n5 VPWR.t1 64.9686
R26 VPWR.n0 VPWR.t6 34.6247
R27 VPWR.n0 VPWR.t7 33.4308
R28 VPWR.n15 VPWR.n14 32.7116
R29 VPWR.n17 VPWR.n8 32.7116
R30 VPWR.n21 VPWR.n8 32.7116
R31 VPWR.n22 VPWR.n21 32.7116
R32 VPWR.n23 VPWR.n22 32.7116
R33 VPWR.n27 VPWR.n26 32.7116
R34 VPWR.n28 VPWR.n27 32.7116
R35 VPWR.n28 VPWR.n3 32.7116
R36 VPWR.n32 VPWR.n3 32.7116
R37 VPWR.n35 VPWR.n34 32.7116
R38 VPWR.n35 VPWR.n1 31.6449
R39 VPWR.n14 VPWR.n11 31.2894
R40 VPWR.n17 VPWR.n16 27.3783
R41 VPWR.n33 VPWR.n32 26.6672
R42 VPWR.n23 VPWR.n6 20.9783
R43 VPWR.n26 VPWR.n6 11.7338
R44 VPWR.n36 VPWR.n35 9.3005
R45 VPWR.n34 VPWR.n2 9.3005
R46 VPWR.n32 VPWR.n31 9.3005
R47 VPWR.n30 VPWR.n3 9.3005
R48 VPWR.n29 VPWR.n28 9.3005
R49 VPWR.n27 VPWR.n4 9.3005
R50 VPWR.n26 VPWR.n25 9.3005
R51 VPWR.n24 VPWR.n23 9.3005
R52 VPWR.n22 VPWR.n7 9.3005
R53 VPWR.n21 VPWR.n20 9.3005
R54 VPWR.n19 VPWR.n8 9.3005
R55 VPWR.n18 VPWR.n17 9.3005
R56 VPWR.n15 VPWR.n9 9.3005
R57 VPWR.n14 VPWR.n13 9.3005
R58 VPWR.n37 VPWR.n1 8.66433
R59 VPWR.n12 VPWR.n11 8.45154
R60 VPWR.n34 VPWR.n33 6.04494
R61 VPWR.n16 VPWR.n15 5.33383
R62 VPWR.n13 VPWR.n12 0.653987
R63 VPWR.n37 VPWR.n36 0.142453
R64 VPWR VPWR.n37 0.120987
R65 VPWR.n13 VPWR.n9 0.120292
R66 VPWR.n18 VPWR.n9 0.120292
R67 VPWR.n19 VPWR.n18 0.120292
R68 VPWR.n20 VPWR.n19 0.120292
R69 VPWR.n20 VPWR.n7 0.120292
R70 VPWR.n24 VPWR.n7 0.120292
R71 VPWR.n25 VPWR.n24 0.120292
R72 VPWR.n25 VPWR.n4 0.120292
R73 VPWR.n29 VPWR.n4 0.120292
R74 VPWR.n30 VPWR.n29 0.120292
R75 VPWR.n31 VPWR.n30 0.120292
R76 VPWR.n31 VPWR.n2 0.120292
R77 VPWR.n36 VPWR.n2 0.120292
R78 D.n0 D.t0 244.018
R79 D.n0 D.t1 240.804
R80 D D.n0 158.788
R81 VGND.n12 VGND.t3 254.204
R82 VGND.n11 VGND.t2 244.177
R83 VGND.n33 VGND.t6 242.368
R84 VGND.n16 VGND.n10 209.847
R85 VGND.n6 VGND.n5 209.847
R86 VGND.n1 VGND.n0 209.471
R87 VGND.n5 VGND.t0 52.5848
R88 VGND.n10 VGND.t4 51.79
R89 VGND.n10 VGND.t1 39.1584
R90 VGND.n5 VGND.t8 33.0384
R91 VGND.n15 VGND.n14 30.99
R92 VGND.n17 VGND.n8 30.99
R93 VGND.n21 VGND.n8 30.99
R94 VGND.n22 VGND.n21 30.99
R95 VGND.n23 VGND.n22 30.99
R96 VGND.n27 VGND.n26 30.99
R97 VGND.n28 VGND.n27 30.99
R98 VGND.n28 VGND.n3 30.99
R99 VGND.n32 VGND.n3 30.99
R100 VGND.n35 VGND.n34 30.99
R101 VGND.n0 VGND.t5 30.797
R102 VGND.n35 VGND.n1 29.9794
R103 VGND.n0 VGND.t7 29.735
R104 VGND.n14 VGND.n11 29.6426
R105 VGND.n17 VGND.n16 26.611
R106 VGND.n33 VGND.n32 25.2637
R107 VGND.n23 VGND.n6 17.1794
R108 VGND.n26 VGND.n6 13.811
R109 VGND.n36 VGND.n35 9.3005
R110 VGND.n34 VGND.n2 9.3005
R111 VGND.n32 VGND.n31 9.3005
R112 VGND.n30 VGND.n3 9.3005
R113 VGND.n29 VGND.n28 9.3005
R114 VGND.n27 VGND.n4 9.3005
R115 VGND.n26 VGND.n25 9.3005
R116 VGND.n24 VGND.n23 9.3005
R117 VGND.n22 VGND.n7 9.3005
R118 VGND.n21 VGND.n20 9.3005
R119 VGND.n19 VGND.n8 9.3005
R120 VGND.n18 VGND.n17 9.3005
R121 VGND.n15 VGND.n9 9.3005
R122 VGND.n14 VGND.n13 9.3005
R123 VGND.n37 VGND.n1 8.5492
R124 VGND.n12 VGND.n11 8.28492
R125 VGND.n34 VGND.n33 5.72682
R126 VGND.n16 VGND.n15 4.37945
R127 VGND.n13 VGND.n12 0.681255
R128 VGND.n37 VGND.n36 0.143203
R129 VGND.n13 VGND.n9 0.120292
R130 VGND.n18 VGND.n9 0.120292
R131 VGND.n19 VGND.n18 0.120292
R132 VGND.n20 VGND.n19 0.120292
R133 VGND.n20 VGND.n7 0.120292
R134 VGND.n24 VGND.n7 0.120292
R135 VGND.n25 VGND.n24 0.120292
R136 VGND.n25 VGND.n4 0.120292
R137 VGND.n29 VGND.n4 0.120292
R138 VGND.n30 VGND.n29 0.120292
R139 VGND.n31 VGND.n30 0.120292
R140 VGND.n31 VGND.n2 0.120292
R141 VGND.n36 VGND.n2 0.120292
R142 VGND VGND.n37 0.120227
R143 Q Q.n0 623.275
R144 Q Q.n1 223.691
R145 Q.n0 Q.t1 27.8591
R146 Q.n0 Q.t0 27.8591
R147 Q.n1 Q.t2 26.047
R148 Q.n1 Q.t3 26.047
R149 VNB.t8 VNB.t10 2810.32
R150 VNB.t3 VNB.t6 2696.77
R151 VNB.t7 VNB.t5 2469.68
R152 VNB.t2 VNB.t0 2441.29
R153 VNB.t9 VNB.t2 1618.06
R154 VNB.t1 VNB.t7 1589.68
R155 VNB.t12 VNB.t1 1561.29
R156 VNB.t5 VNB.t3 1447.74
R157 VNB.t0 VNB.t12 1419.35
R158 VNB.t10 VNB.t9 1419.35
R159 VNB.t11 VNB.t8 1234.84
R160 VNB.t6 VNB.t4 1220.65
R161 VNB VNB.t11 738.066
C0 a_992_410# a_28_331# 0.16904f
C1 CLK a_28_331# 0.18642f
C2 a_1106_49# a_992_410# 0.00732f
C3 a_612_49# a_496_412# 0.00696f
C4 VPWR D 0.0295f
C5 a_754_23# VPWR 0.06362f
C6 a_496_412# a_28_331# 0.13878f
C7 a_1110_410# a_1250_23# 0
C8 Q a_1250_23# 0.12323f
C9 a_398_49# a_612_49# 0
C10 D VPB 0.08628f
C11 a_754_23# VPB 0.08637f
C12 a_398_49# a_28_331# 0.06329f
C13 a_992_410# a_496_412# 0
C14 a_754_23# a_614_412# 0
C15 D a_200_49# 0.11807f
C16 a_754_23# a_200_49# 0.14973f
C17 a_1110_410# a_28_331# 0.0037f
C18 VGND D 0.03521f
C19 VGND a_754_23# 0.08139f
C20 Q a_28_331# 0.00197f
C21 VPWR a_1250_23# 0.16602f
C22 a_992_410# a_1110_410# 0.01437f
C23 a_1250_23# VPB 0.18f
C24 a_992_410# Q 0.00123f
C25 a_398_49# a_496_412# 0.06041f
C26 a_1250_23# a_200_49# 0.02234f
C27 VPWR a_28_331# 0.20376f
C28 VGND a_1250_23# 0.18544f
C29 a_1106_49# VPWR 0
C30 a_28_331# VPB 0.24896f
C31 a_992_410# VPWR 0.11724f
C32 VPWR CLK 0.01776f
C33 a_612_49# a_200_49# 0.00302f
C34 VGND a_612_49# 0.01384f
C35 a_200_49# a_28_331# 0.68682f
C36 VGND a_28_331# 0.64211f
C37 a_992_410# VPB 0.11899f
C38 a_1106_49# VGND 0.0152f
C39 CLK VPB 0.05317f
C40 VPWR a_496_412# 0.10904f
C41 a_992_410# a_200_49# 0.07717f
C42 a_992_410# VGND 0.06118f
C43 a_200_49# CLK 0.00122f
C44 VPWR a_398_49# 0.04978f
C45 a_496_412# VPB 0.10648f
C46 VGND CLK 0.01775f
C47 a_754_23# a_1250_23# 0
C48 a_614_412# a_496_412# 0.01425f
C49 a_398_49# VPB 0.01177f
C50 a_200_49# a_496_412# 0.20205f
C51 a_1110_410# VPWR 0.01632f
C52 VGND a_496_412# 0.05547f
C53 VPWR Q 0.14698f
C54 a_614_412# a_398_49# 0
C55 a_398_49# a_200_49# 0.07734f
C56 a_754_23# a_612_49# 0
C57 VGND a_398_49# 0.05246f
C58 D a_28_331# 0.08545f
C59 Q VPB 0.00679f
C60 a_754_23# a_28_331# 0.08721f
C61 a_1106_49# a_754_23# 0
C62 VGND a_1110_410# 0
C63 Q a_200_49# 0
C64 VGND Q 0.12151f
C65 a_992_410# a_754_23# 0.05912f
C66 VPWR VPB 0.22631f
C67 a_1250_23# a_28_331# 0.06543f
C68 VPWR a_614_412# 0.01637f
C69 D a_496_412# 0
C70 a_754_23# a_496_412# 0.21192f
C71 a_1106_49# a_1250_23# 0
C72 VPWR a_200_49# 0.28536f
C73 VGND VPWR 0.09472f
C74 a_398_49# D 0.07902f
C75 a_754_23# a_398_49# 0
C76 a_992_410# a_1250_23# 0.24462f
C77 a_200_49# VPB 0.21733f
C78 a_612_49# a_28_331# 0.0081f
C79 VGND VPB 0.01977f
C80 a_614_412# a_200_49# 0.00554f
C81 a_1110_410# a_754_23# 0
C82 a_1106_49# a_28_331# 0.0094f
C83 VGND a_200_49# 0.11025f
C84 Q VNB 0.02069f
C85 VGND VNB 1.03316f
C86 VPWR VNB 0.84056f
C87 D VNB 0.12f
C88 CLK VNB 0.15485f
C89 VPB VNB 1.75104f
C90 a_398_49# VNB 0.01536f
C91 a_992_410# VNB 0.13555f
C92 a_1250_23# VNB 0.38144f
C93 a_496_412# VNB 0.12216f
C94 a_754_23# VNB 0.13768f
C95 a_200_49# VNB 0.34203f
C96 a_28_331# VNB 0.57166f
.ends
