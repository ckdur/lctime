* NGSPICE file created from sky130_as_sc_hs__aoi211_2.ext - technology: sky130A

.subckt sky130_as_sc_hs__aoi211_2 VPB VPWR VGND A B C D Y
R1122 VPB VPWR 0
R1111 VNB VGND 0
X0 VGND.t5 A.t0 a_27_49# VNB.t7 sky130_fd_pr__nfet_01v8_lvt ad=0.0903 pd=0.925 as=0.17093 ps=1.82 w=0.645 l=0.15
X1 Y.t7 C.t0 VGND.t3 VNB.t3 sky130_fd_pr__nfet_01v8_lvt ad=0.0903 pd=0.925 as=0.17093 ps=1.82 w=0.645 l=0.15
X2 VPWR.t3 A.t1 a_110_298# VPB.t5 sky130_fd_pr__pfet_01v8 ad=0.1386 pd=1.27 as=0.1386 ps=1.27 w=0.99 l=0.15
X3 a_110_298# A.t2 VPWR.t2 VPB.t4 sky130_fd_pr__pfet_01v8 ad=0.1386 pd=1.27 as=0.26235 ps=2.51 w=0.99 l=0.15
X4 a_110_298# C.t1 a_475_298# VPB.t7 sky130_fd_pr__pfet_01v8 ad=0.1386 pd=1.27 as=0.26235 ps=2.51 w=0.99 l=0.15
X5 a_110_298# B.t0 VPWR.t0 VPB.t2 sky130_fd_pr__pfet_01v8 ad=0.1386 pd=1.27 as=0.1386 ps=1.27 w=0.99 l=0.15
X6 Y.t3 D.t0 VGND.t2 VNB.t2 sky130_fd_pr__nfet_01v8_lvt ad=0.0903 pd=0.925 as=0.0903 ps=0.925 w=0.645 l=0.15
X7 Y.t5 B.t1 a_27_49# VNB.t5 sky130_fd_pr__nfet_01v8_lvt ad=0.0903 pd=0.925 as=0.0903 ps=0.925 w=0.645 l=0.15
X8 a_475_298# C.t2 a_110_298# VPB.t6 sky130_fd_pr__pfet_01v8 ad=0.1386 pd=1.27 as=0.1386 ps=1.27 w=0.99 l=0.15
X9 VPWR.t1 B.t2 a_110_298# VPB.t3 sky130_fd_pr__pfet_01v8 ad=0.26235 pd=2.51 as=0.1386 ps=1.27 w=0.99 l=0.15
X10 VGND.t1 D.t1 Y.t2 VNB.t1 sky130_fd_pr__nfet_01v8_lvt ad=0.18383 pd=1.86 as=0.0903 ps=0.925 w=0.645 l=0.15
X11 a_27_49# B.t3 Y.t4 VNB.t4 sky130_fd_pr__nfet_01v8_lvt ad=0.17093 pd=1.82 as=0.0903 ps=0.925 w=0.645 l=0.15
X12 VGND.t0 C.t3 Y.t6 VNB.t0 sky130_fd_pr__nfet_01v8_lvt ad=0.0903 pd=0.925 as=0.0903 ps=0.925 w=0.645 l=0.15
X13 Y.t1 D.t2 a_475_298# VPB.t1 sky130_fd_pr__pfet_01v8 ad=0.1386 pd=1.27 as=0.1386 ps=1.27 w=0.99 l=0.15
X14 a_27_49# A.t3 VGND.t4 VNB.t6 sky130_fd_pr__nfet_01v8_lvt ad=0.0903 pd=0.925 as=0.0903 ps=0.925 w=0.645 l=0.15
X15 a_475_298# D.t3 Y.t0 VPB.t0 sky130_fd_pr__pfet_01v8 ad=0.26235 pd=2.51 as=0.1386 ps=1.27 w=0.99 l=0.15
R0 A.n0 A.t1 197.62
R1 A.n1 A.t2 197.62
R2 A.n3 A.n2 152
R3 A.n0 A.t3 149.421
R4 A.n1 A.t0 149.421
R5 A.n2 A.n0 59.5417
R6 A A.n3 3.0725
R7 A.n2 A.n1 1.41815
R8 A.n3 A 1.2805
R9 VGND.n7 VGND.t3 284.382
R10 VGND.n5 VGND.n4 206.819
R11 VGND.n14 VGND.n13 206.237
R12 VGND.n3 VGND.t1 160.852
R13 VGND.n11 VGND.n1 30.99
R14 VGND.n12 VGND.n11 30.99
R15 VGND.n4 VGND.t2 26.047
R16 VGND.n4 VGND.t0 26.047
R17 VGND.n13 VGND.t4 26.047
R18 VGND.n13 VGND.t5 26.047
R19 VGND.n7 VGND.n6 25.6005
R20 VGND.n14 VGND.n12 23.5794
R21 VGND.n7 VGND.n1 21.5584
R22 VGND.n6 VGND.n5 17.5163
R23 VGND.n8 VGND.n7 9.88232
R24 VGND.n12 VGND.n0 9.3005
R25 VGND.n11 VGND.n10 9.3005
R26 VGND.n9 VGND.n1 9.3005
R27 VGND.n6 VGND.n2 9.3005
R28 VGND.n15 VGND.n14 7.57795
R29 VGND.n5 VGND.n3 7.06326
R30 VGND.n3 VGND.n2 0.842952
R31 VGND.n15 VGND.n0 0.148398
R32 VGND.n8 VGND.n2 0.120292
R33 VGND.n9 VGND.n8 0.120292
R34 VGND.n10 VGND.n9 0.120292
R35 VGND.n10 VGND.n0 0.120292
R36 VGND VGND.n15 0.114986
R37 VNB.t4 VNB.t3 2696.77
R38 VNB.t2 VNB.t1 1220.65
R39 VNB.t0 VNB.t2 1220.65
R40 VNB.t3 VNB.t0 1220.65
R41 VNB.t5 VNB.t4 1220.65
R42 VNB.t6 VNB.t5 1220.65
R43 VNB.t7 VNB.t6 1220.65
R44 VNB VNB.t7 695.485
R45 C.n0 C.t2 194.407
R46 C.n1 C.t1 194.407
R47 C C.n2 152
R48 C.n0 C.t3 149.421
R49 C.n1 C.t0 149.421
R50 C.n2 C.n0 46.8234
R51 C.n2 C.n1 12.3948
R52 Y Y.n0 623.773
R53 Y.n4 Y.n2 273.394
R54 Y.n5 Y.n1 207.756
R55 Y.n4 Y.n3 199.081
R56 Y.n5 Y.n4 40.1783
R57 Y.n0 Y.t0 27.8591
R58 Y.n0 Y.t1 27.8591
R59 Y.n2 Y.t4 26.047
R60 Y.n2 Y.t5 26.047
R61 Y.n3 Y.t6 26.047
R62 Y.n3 Y.t7 26.047
R63 Y.n1 Y.t2 26.047
R64 Y.n1 Y.t3 26.047
R65 Y Y.n5 9.24494
R66 VPWR.n1 VPWR.t1 646.914
R67 VPWR.n3 VPWR.n2 612.928
R68 VPWR.n5 VPWR.t2 358.76
R69 VPWR.n2 VPWR.t0 27.8591
R70 VPWR.n2 VPWR.t3 27.8591
R71 VPWR.n4 VPWR.n3 22.7561
R72 VPWR.n5 VPWR.n4 22.7561
R73 VPWR.n6 VPWR.n5 9.3005
R74 VPWR.n4 VPWR.n0 9.3005
R75 VPWR.n3 VPWR.n1 6.84751
R76 VPWR.n1 VPWR.n0 0.576868
R77 VPWR.n6 VPWR.n0 0.120292
R78 VPWR VPWR.n6 0.0226354
R79 VPB.t3 VPB.t7 564.062
R80 VPB.t1 VPB.t0 255.312
R81 VPB.t6 VPB.t1 255.312
R82 VPB.t7 VPB.t6 255.312
R83 VPB.t2 VPB.t3 255.312
R84 VPB.t5 VPB.t2 255.312
R85 VPB.t4 VPB.t5 255.312
R86 VPB VPB.t4 145.47
R87 B.n0 B.t2 194.407
R88 B.n1 B.t0 194.407
R89 B.n3 B.n2 152
R90 B.n0 B.t3 149.421
R91 B.n1 B.t1 149.421
R92 B.n2 B.n0 46.8234
R93 B.n2 B.n1 12.3948
R94 B B.n3 3.3285
R95 B.n3 B 1.0245
R96 D.n1 D.t3 194.407
R97 D.n0 D.t2 194.407
R98 D.n2 D.n1 160.263
R99 D.n1 D.t1 149.421
R100 D.n0 D.t0 149.421
R101 D.n1 D.n0 59.2176
R102 D D.n2 3.5845
R103 D.n2 D 0.7685
C0 VPWR a_475_298# 0.24104f
C1 VPWR VPB 0.11741f
C2 A VPB 0.06045f
C3 VGND C 0.03556f
C4 VPWR a_110_298# 0.31907f
C5 A a_110_298# 0.0524f
C6 Y D 0.08867f
C7 VPB a_475_298# 0.01459f
C8 VGND B 0.02057f
C9 a_110_298# a_475_298# 0.09203f
C10 C B 0.02778f
C11 VPB a_110_298# 0.01541f
C12 VGND a_27_49# 0.25438f
C13 C a_27_49# 0
C14 VPWR D 0.01758f
C15 D a_475_298# 0.04672f
C16 D VPB 0.06445f
C17 VGND Y 0.27066f
C18 B a_27_49# 0.02405f
C19 C Y 0.11613f
C20 D a_110_298# 0
C21 VGND VPWR 0.09346f
C22 VGND A 0.03445f
C23 VPWR C 0.01893f
C24 B Y 0.06062f
C25 Y a_27_49# 0.08844f
C26 VGND a_475_298# 0.00657f
C27 VGND VPB 0.01306f
C28 C a_475_298# 0.03016f
C29 C VPB 0.05825f
C30 VPWR B 0.03953f
C31 A B 0.06432f
C32 VPWR a_27_49# 0.00928f
C33 A a_27_49# 0.08007f
C34 VGND a_110_298# 0.00726f
C35 C a_110_298# 0.05927f
C36 B VPB 0.058f
C37 VPB a_27_49# 0.0013f
C38 VGND D 0.05911f
C39 VPWR Y 0.01256f
C40 A Y 0
C41 C D 0.04914f
C42 B a_110_298# 0.07908f
C43 a_27_49# a_110_298# 0.00814f
C44 VPWR A 0.05141f
C45 Y a_475_298# 0.09955f
C46 Y VPB 0.01066f
C47 Y a_110_298# 0.02765f
C48 VGND VNB 0.56617f
C49 Y VNB 0.04094f
C50 VPWR VNB 0.46488f
C51 D VNB 0.22303f
C52 C VNB 0.18469f
C53 B VNB 0.18434f
C54 A VNB 0.21656f
C55 VPB VNB 0.95616f
C56 a_27_49# VNB 0.03488f
C57 a_475_298# VNB 0.02784f
C58 a_110_298# VNB 0.00751f
.ends
