* NGSPICE file created from sky130_as_sc_hs__clkbuff_8.ext - technology: sky130A

.subckt sky130_as_sc_hs__clkbuff_8 VPB VPWR VGND VNB Y A
X0 a_111_49# A.t0 VGND.t1 VNB.t1 sky130_fd_pr__nfet_01v8_lvt ad=0.06197 pd=0.72 as=0.11528 ps=1.4 w=0.435 l=0.15
X1 VGND.t4 a_111_49# Y.t15 VNB.t9 sky130_fd_pr__nfet_01v8_lvt ad=0.06307 pd=0.725 as=0.06307 ps=0.725 w=0.435 l=0.15
X2 Y.t2 a_111_49# VPWR.t9 VPB.t9 sky130_fd_pr__pfet_01v8 ad=0.14355 pd=1.28 as=0.14355 ps=1.28 w=0.99 l=0.15
X3 VGND.t7 a_111_49# Y.t14 VNB.t8 sky130_fd_pr__nfet_01v8_lvt ad=0.06307 pd=0.725 as=0.06742 ps=0.745 w=0.435 l=0.15
X4 Y.t1 a_111_49# VPWR.t8 VPB.t8 sky130_fd_pr__pfet_01v8 ad=0.14355 pd=1.28 as=0.14355 ps=1.28 w=0.99 l=0.15
X5 Y.t0 a_111_49# VPWR.t7 VPB.t7 sky130_fd_pr__pfet_01v8 ad=0.14355 pd=1.28 as=0.14355 ps=1.28 w=0.99 l=0.15
X6 VGND.t5 a_111_49# Y.t13 VNB.t7 sky130_fd_pr__nfet_01v8_lvt ad=0.12615 pd=1.45 as=0.06307 ps=0.725 w=0.435 l=0.15
X7 Y.t5 a_111_49# VPWR.t6 VPB.t6 sky130_fd_pr__pfet_01v8 ad=0.15345 pd=1.3 as=0.14355 ps=1.28 w=0.99 l=0.15
X8 Y.t12 a_111_49# VGND.t3 VNB.t6 sky130_fd_pr__nfet_01v8_lvt ad=0.06307 pd=0.725 as=0.06307 ps=0.725 w=0.435 l=0.15
X9 a_111_49# A.t1 VPWR.t1 VPB.t1 sky130_fd_pr__pfet_01v8 ad=0.14108 pd=1.275 as=0.26235 ps=2.51 w=0.99 l=0.15
X10 VGND.t9 a_111_49# Y.t11 VNB.t5 sky130_fd_pr__nfet_01v8_lvt ad=0.06307 pd=0.725 as=0.06307 ps=0.725 w=0.435 l=0.15
X11 VPWR.t0 A.t2 a_111_49# VPB.t0 sky130_fd_pr__pfet_01v8 ad=0.14355 pd=1.28 as=0.14108 ps=1.275 w=0.99 l=0.15
X12 Y.t10 a_111_49# VGND.t2 VNB.t4 sky130_fd_pr__nfet_01v8_lvt ad=0.06307 pd=0.725 as=0.06307 ps=0.725 w=0.435 l=0.15
X13 VPWR.t5 a_111_49# Y.t4 VPB.t5 sky130_fd_pr__pfet_01v8 ad=0.14355 pd=1.28 as=0.15345 ps=1.3 w=0.99 l=0.15
X14 Y.t9 a_111_49# VGND.t8 VNB.t3 sky130_fd_pr__nfet_01v8_lvt ad=0.06742 pd=0.745 as=0.06307 ps=0.725 w=0.435 l=0.15
X15 VPWR.t4 a_111_49# Y.t3 VPB.t4 sky130_fd_pr__pfet_01v8 ad=0.14355 pd=1.28 as=0.14355 ps=1.28 w=0.99 l=0.15
X16 VGND.t0 A.t3 a_111_49# VNB.t0 sky130_fd_pr__nfet_01v8_lvt ad=0.06307 pd=0.725 as=0.06197 ps=0.72 w=0.435 l=0.15
X17 VPWR.t3 a_111_49# Y.t6 VPB.t3 sky130_fd_pr__pfet_01v8 ad=0.2673 pd=2.52 as=0.14355 ps=1.28 w=0.99 l=0.15
X18 Y.t8 a_111_49# VGND.t6 VNB.t2 sky130_fd_pr__nfet_01v8_lvt ad=0.06307 pd=0.725 as=0.06307 ps=0.725 w=0.435 l=0.15
X19 VPWR.t2 a_111_49# Y.t7 VPB.t2 sky130_fd_pr__pfet_01v8 ad=0.14355 pd=1.28 as=0.14355 ps=1.28 w=0.99 l=0.15
R0 A.n0 A.t2 207.261
R1 A.n1 A.t1 207.261
R2 A.n0 A.t3 179.947
R3 A.n1 A.t0 179.947
R4 A A.n2 78.1338
R5 A.n2 A.n0 41.4224
R6 A.n2 A.n1 24.1005
R7 VGND.n8 VGND.t5 250.582
R8 VGND.n20 VGND.t1 246.149
R9 VGND.n7 VGND.n6 203.945
R10 VGND.n11 VGND.n5 203.945
R11 VGND.n14 VGND.n13 203.689
R12 VGND.n18 VGND.n2 203.689
R13 VGND.n6 VGND.t2 40.0005
R14 VGND.n6 VGND.t9 40.0005
R15 VGND.n5 VGND.t6 40.0005
R16 VGND.n5 VGND.t7 40.0005
R17 VGND.n13 VGND.t8 40.0005
R18 VGND.n13 VGND.t4 40.0005
R19 VGND.n2 VGND.t3 40.0005
R20 VGND.n2 VGND.t0 40.0005
R21 VGND.n11 VGND.n4 27.6216
R22 VGND.n14 VGND.n12 26.2742
R23 VGND.n18 VGND.n1 23.5794
R24 VGND.n19 VGND.n18 21.5584
R25 VGND.n20 VGND.n19 20.211
R26 VGND.n14 VGND.n1 18.8637
R27 VGND.n12 VGND.n11 17.5163
R28 VGND.n7 VGND.n4 14.8216
R29 VGND.n11 VGND.n10 9.8125
R30 VGND.n15 VGND.n14 9.8125
R31 VGND.n18 VGND.n17 9.8125
R32 VGND.n21 VGND.n20 9.8125
R33 VGND.n19 VGND.n0 9.3005
R34 VGND.n16 VGND.n1 9.3005
R35 VGND.n12 VGND.n3 9.3005
R36 VGND.n9 VGND.n4 9.3005
R37 VGND.n8 VGND.n7 7.05878
R38 VGND.n9 VGND.n8 0.822975
R39 VGND.n10 VGND.n9 0.120292
R40 VGND.n10 VGND.n3 0.120292
R41 VGND.n15 VGND.n3 0.120292
R42 VGND.n16 VGND.n15 0.120292
R43 VGND.n17 VGND.n16 0.120292
R44 VGND.n17 VGND.n0 0.120292
R45 VGND.n21 VGND.n0 0.120292
R46 VGND VGND.n21 0.0226354
R47 VNB.t3 VNB.t8 1305.81
R48 VNB.t4 VNB.t7 1249.03
R49 VNB.t5 VNB.t4 1249.03
R50 VNB.t2 VNB.t5 1249.03
R51 VNB.t8 VNB.t2 1249.03
R52 VNB.t9 VNB.t3 1249.03
R53 VNB.t6 VNB.t9 1249.03
R54 VNB.t0 VNB.t6 1249.03
R55 VNB.t1 VNB.t0 1234.84
R56 VNB VNB.t1 709.678
R57 Y.n2 Y.n0 369.01
R58 Y.n2 Y.n1 317.519
R59 Y.n4 Y.n3 312.885
R60 Y.n6 Y.n5 310.122
R61 Y.n9 Y.n7 256.459
R62 Y.n9 Y.n8 204.506
R63 Y.n11 Y.n10 201.385
R64 Y.n13 Y.n12 198.298
R65 Y.n11 Y.n9 47.4358
R66 Y.n4 Y.n2 45.9299
R67 Y.n8 Y.t9 45.5177
R68 Y.n13 Y.n11 42.9181
R69 Y.n6 Y.n4 42.1652
R70 Y.n7 Y.t15 40.0005
R71 Y.n7 Y.t12 40.0005
R72 Y.n8 Y.t14 40.0005
R73 Y.n10 Y.t11 40.0005
R74 Y.n10 Y.t8 40.0005
R75 Y.n12 Y.t13 40.0005
R76 Y.n12 Y.t10 40.0005
R77 Y.n1 Y.t5 32.8338
R78 Y.n0 Y.t3 28.854
R79 Y.n0 Y.t2 28.854
R80 Y.n1 Y.t4 28.854
R81 Y.n3 Y.t7 28.854
R82 Y.n3 Y.t0 28.854
R83 Y.n5 Y.t6 28.854
R84 Y.n5 Y.t1 28.854
R85 Y Y.n13 1.78655
R86 Y Y.n6 0.967942
R87 VPWR.n6 VPWR.t3 646.145
R88 VPWR.n18 VPWR.n17 611.074
R89 VPWR.n5 VPWR.n4 610.837
R90 VPWR.n10 VPWR.n9 610.837
R91 VPWR.n13 VPWR.n12 610.837
R92 VPWR.n20 VPWR.t1 354.019
R93 VPWR.n4 VPWR.t8 28.854
R94 VPWR.n4 VPWR.t2 28.854
R95 VPWR.n9 VPWR.t7 28.854
R96 VPWR.n9 VPWR.t5 28.854
R97 VPWR.n12 VPWR.t6 28.854
R98 VPWR.n12 VPWR.t4 28.854
R99 VPWR.n17 VPWR.t9 28.854
R100 VPWR.n17 VPWR.t0 28.854
R101 VPWR.n10 VPWR.n3 28.4449
R102 VPWR.n13 VPWR.n11 27.0227
R103 VPWR.n18 VPWR.n1 24.1783
R104 VPWR.n19 VPWR.n18 22.0449
R105 VPWR.n20 VPWR.n19 20.6227
R106 VPWR.n13 VPWR.n1 19.2005
R107 VPWR.n11 VPWR.n10 17.7783
R108 VPWR.n5 VPWR.n3 14.9338
R109 VPWR.n21 VPWR.n20 9.3005
R110 VPWR.n19 VPWR.n0 9.3005
R111 VPWR.n18 VPWR.n16 9.3005
R112 VPWR.n15 VPWR.n1 9.3005
R113 VPWR.n14 VPWR.n13 9.3005
R114 VPWR.n11 VPWR.n2 9.3005
R115 VPWR.n10 VPWR.n8 9.3005
R116 VPWR.n7 VPWR.n3 9.3005
R117 VPWR.n6 VPWR.n5 6.83508
R118 VPWR.n7 VPWR.n6 0.759184
R119 VPWR.n8 VPWR.n7 0.120292
R120 VPWR.n8 VPWR.n2 0.120292
R121 VPWR.n14 VPWR.n2 0.120292
R122 VPWR.n15 VPWR.n14 0.120292
R123 VPWR.n16 VPWR.n15 0.120292
R124 VPWR.n16 VPWR.n0 0.120292
R125 VPWR.n21 VPWR.n0 0.120292
R126 VPWR VPWR.n21 0.0226354
R127 VPB.t6 VPB.t5 273.125
R128 VPB.t8 VPB.t3 261.25
R129 VPB.t2 VPB.t8 261.25
R130 VPB.t7 VPB.t2 261.25
R131 VPB.t5 VPB.t7 261.25
R132 VPB.t4 VPB.t6 261.25
R133 VPB.t9 VPB.t4 261.25
R134 VPB.t0 VPB.t9 261.25
R135 VPB.t1 VPB.t0 258.281
R136 VPB VPB.t1 148.439
C0 VPWR VPB 0.12286f
C1 VPB A 0.06325f
C2 VPWR a_111_49# 0.37619f
C3 a_111_49# A 0.2201f
C4 VPWR VGND 0.10387f
C5 VGND A 0.06634f
C6 a_111_49# VPB 0.27368f
C7 VPWR Y 0.6954f
C8 Y A 0
C9 VGND VPB 0.00937f
C10 Y VPB 0.02187f
C11 VGND a_111_49# 0.27354f
C12 Y a_111_49# 0.76617f
C13 Y VGND 0.46876f
C14 VPWR A 0.07222f
C15 VGND VNB 0.60425f
C16 Y VNB 0.09678f
C17 VPWR VNB 0.51438f
C18 A VNB 0.26776f
C19 VPB VNB 1.0464f
C20 a_111_49# VNB 0.89475f
.ends
