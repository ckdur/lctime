* NGSPICE file created from sky130_as_sc_hs__xnor2_2.ext - technology: sky130A

.subckt sky130_as_sc_hs__xnor2_2 VPB VNB VPWR VGND B A Y
X0 VGND.t1 B.t0 a_284_23# VNB.t2 sky130_fd_pr__nfet_01v8_lvt ad=0.129 pd=1.045 as=0.15802 ps=1.135 w=0.645 l=0.15
X1 VGND.t0 A.t0 a_27_49# VNB.t0 sky130_fd_pr__nfet_01v8_lvt ad=0.09652 pd=0.915 as=0.15503 ps=1.7 w=0.585 l=0.15
X2 a_314_49# a_284_23# a_196_347# VPB.t1 sky130_fd_pr__pfet_01v8 ad=0.297 pd=1.59 as=0.19697 ps=1.43 w=0.99 l=0.15
X3 a_206_49# a_27_49# VGND.t4 VNB.t6 sky130_fd_pr__nfet_01v8_lvt ad=0.12218 pd=1.035 as=0.09652 ps=0.915 w=0.585 l=0.15
X4 a_314_49# a_284_23# a_206_49# VNB.t3 sky130_fd_pr__nfet_01v8_lvt ad=0.37088 pd=1.795 as=0.12218 ps=1.035 w=0.645 l=0.15
X5 a_196_347# A.t1 VPWR.t3 VPB.t5 sky130_fd_pr__pfet_01v8 ad=0.19697 pd=1.43 as=0.1043 ps=1.025 w=0.745 l=0.15
X6 VPWR.t4 A.t2 a_27_49# VPB.t4 sky130_fd_pr__pfet_01v8 ad=0.1043 pd=1.025 as=0.19742 ps=2.02 w=0.745 l=0.15
X7 Y.t1 a_314_49# VPWR.t2 VPB.t3 sky130_fd_pr__pfet_01v8 ad=0.18563 pd=1.365 as=0.198 ps=1.39 w=0.99 l=0.15
X8 VGND.t3 a_314_49# Y.t3 VNB.t5 sky130_fd_pr__nfet_01v8_lvt ad=0.21608 pd=1.96 as=0.12093 ps=1.02 w=0.645 l=0.15
X9 a_284_23# A.t3 a_314_49# VNB.t1 sky130_fd_pr__nfet_01v8_lvt ad=0.15802 pd=1.135 as=0.37088 ps=1.795 w=0.645 l=0.15
X10 a_284_23# a_27_49# a_314_49# VPB.t6 sky130_fd_pr__pfet_01v8 ad=0.5148 pd=2.03 as=0.297 ps=1.59 w=0.99 l=0.15
X11 VPWR.t0 B.t1 a_284_23# VPB.t0 sky130_fd_pr__pfet_01v8 ad=0.198 pd=1.39 as=0.5148 ps=2.03 w=0.99 l=0.15
X12 VPWR.t1 a_314_49# Y.t0 VPB.t2 sky130_fd_pr__pfet_01v8 ad=0.33165 pd=2.65 as=0.18563 ps=1.365 w=0.99 l=0.15
X13 Y.t2 a_314_49# VGND.t2 VNB.t4 sky130_fd_pr__nfet_01v8_lvt ad=0.12093 pd=1.02 as=0.129 ps=1.045 w=0.645 l=0.15
R0 B.n0 B.t1 233.865
R1 B.n0 B.t0 163.172
R2 B.n1 B.n0 152
R3 B B.n1 2.32777
R4 B.n1 B 0.970197
R5 VGND.n6 VGND.t3 250.142
R6 VGND.n7 VGND.n5 216.625
R7 VGND.n1 VGND.n0 209.095
R8 VGND.n5 VGND.t2 43.7214
R9 VGND.n0 VGND.t4 38.9749
R10 VGND.n9 VGND.n8 31.8275
R11 VGND.n9 VGND.n3 31.8275
R12 VGND.n13 VGND.n3 31.8275
R13 VGND.n14 VGND.n13 31.1721
R14 VGND.n15 VGND.n14 30.99
R15 VGND.n15 VGND.n1 30.99
R16 VGND.n5 VGND.t1 30.6982
R17 VGND.n0 VGND.t0 28.7184
R18 VGND.n7 VGND.n6 23.182
R19 VGND.n8 VGND.n7 15.5681
R20 VGND.n16 VGND.n15 9.3005
R21 VGND.n14 VGND.n2 9.3005
R22 VGND.n13 VGND.n12 9.3005
R23 VGND.n11 VGND.n3 9.3005
R24 VGND.n10 VGND.n9 9.3005
R25 VGND.n8 VGND.n4 9.3005
R26 VGND.n17 VGND.n1 7.53867
R27 VGND.n6 VGND.n4 0.728277
R28 VGND.n17 VGND.n16 0.143203
R29 VGND.n10 VGND.n4 0.120292
R30 VGND.n11 VGND.n10 0.120292
R31 VGND.n12 VGND.n11 0.120292
R32 VGND.n12 VGND.n2 0.120292
R33 VGND.n16 VGND.n2 0.120292
R34 VGND VGND.n17 0.120227
R35 VNB.t3 VNB.t1 3690.32
R36 VNB.t1 VNB.t2 1816.77
R37 VNB.t2 VNB.t4 1561.29
R38 VNB.t6 VNB.t3 1532.9
R39 VNB.t4 VNB.t5 1490.32
R40 VNB.t0 VNB.t6 1362.58
R41 VNB VNB.t0 695.485
R42 A.n3 A.t3 457.519
R43 A.n0 A.t1 256.264
R44 A.n1 A.t0 219.935
R45 A.n0 A.t2 157.721
R46 A.n3 A.n2 152
R47 A.n2 A.n0 29.4561
R48 A.n2 A.n1 7.14124
R49 A A.n3 2.00834
R50 VPB.t6 VPB.t0 706.562
R51 VPB.t1 VPB.t6 445.312
R52 VPB.t5 VPB.t1 350.312
R53 VPB.t0 VPB.t3 326.562
R54 VPB.t3 VPB.t2 311.719
R55 VPB.t4 VPB.t5 255.312
R56 VPB VPB.t4 145.47
R57 VPWR.n1 VPWR.n0 610.977
R58 VPWR.n7 VPWR.n5 605.707
R59 VPWR.n6 VPWR.t1 382.245
R60 VPWR.n5 VPWR.t2 48.753
R61 VPWR.n0 VPWR.t3 37.0206
R62 VPWR.n0 VPWR.t4 37.0206
R63 VPWR.n9 VPWR.n8 32.7116
R64 VPWR.n9 VPWR.n3 32.7116
R65 VPWR.n13 VPWR.n3 32.7116
R66 VPWR.n14 VPWR.n13 32.7116
R67 VPWR.n15 VPWR.n14 32.7116
R68 VPWR.n15 VPWR.n1 32.7116
R69 VPWR.n5 VPWR.t0 30.8439
R70 VPWR.n7 VPWR.n6 24.5116
R71 VPWR.n8 VPWR.n7 15.2894
R72 VPWR.n16 VPWR.n15 9.3005
R73 VPWR.n14 VPWR.n2 9.3005
R74 VPWR.n13 VPWR.n12 9.3005
R75 VPWR.n11 VPWR.n3 9.3005
R76 VPWR.n10 VPWR.n9 9.3005
R77 VPWR.n8 VPWR.n4 9.3005
R78 VPWR.n17 VPWR.n1 7.59767
R79 VPWR.n6 VPWR.n4 0.593894
R80 VPWR.n17 VPWR.n16 0.142453
R81 VPWR VPWR.n17 0.120987
R82 VPWR.n10 VPWR.n4 0.120292
R83 VPWR.n11 VPWR.n10 0.120292
R84 VPWR.n12 VPWR.n11 0.120292
R85 VPWR.n12 VPWR.n2 0.120292
R86 VPWR.n16 VPWR.n2 0.120292
R87 Y Y.n0 337.387
R88 Y Y.n1 216.377
R89 Y.n0 Y.t1 46.7631
R90 Y.n1 Y.t2 43.7214
R91 Y.n0 Y.t0 27.8591
R92 Y.n1 Y.t3 26.047
C0 VPB VGND 0.01164f
C1 a_27_49# A 0.4321f
C2 VPB a_314_49# 0.07916f
C3 A Y 0
C4 a_196_347# A 0.00857f
C5 VPWR B 0.01667f
C6 VPB a_27_49# 0.07759f
C7 VPB Y 0.00541f
C8 VPWR VGND 0.07108f
C9 a_314_49# VPWR 0.23537f
C10 a_206_49# A 0.0048f
C11 a_27_49# VPWR 0.30062f
C12 VPWR Y 0.09858f
C13 a_196_347# VPWR 0.01191f
C14 A a_284_23# 0.12411f
C15 VPB a_284_23# 0.05869f
C16 B VGND 0.03264f
C17 a_314_49# B 0.10091f
C18 a_206_49# VPWR 0
C19 VPB A 0.12167f
C20 a_27_49# B 0.00698f
C21 a_314_49# VGND 0.10959f
C22 VPWR a_284_23# 0.03668f
C23 B Y 0
C24 a_27_49# VGND 0.13102f
C25 a_314_49# a_27_49# 0.11994f
C26 VGND Y 0.09763f
C27 a_196_347# VGND 0.0012f
C28 a_314_49# Y 0.13421f
C29 a_314_49# a_196_347# 0.0095f
C30 VPWR A 0.06489f
C31 a_27_49# Y 0.00214f
C32 a_196_347# a_27_49# 0.00846f
C33 VPB VPWR 0.11382f
C34 a_206_49# VGND 0.01134f
C35 B a_284_23# 0.03722f
C36 a_206_49# a_314_49# 0.00399f
C37 VGND a_284_23# 0.09058f
C38 a_206_49# a_27_49# 0.00383f
C39 a_314_49# a_284_23# 0.26068f
C40 A B 0.02288f
C41 a_27_49# a_284_23# 0.16502f
C42 A VGND 0.14193f
C43 VPB B 0.0372f
C44 Y a_284_23# 0.00398f
C45 a_314_49# A 0.12604f
C46 VGND VNB 0.61899f
C47 Y VNB 0.04579f
C48 VPWR VNB 0.5229f
C49 B VNB 0.10109f
C50 A VNB 0.30092f
C51 VPB VNB 1.04448f
C52 a_314_49# VNB 0.23185f
C53 a_27_49# VNB 0.27788f
C54 a_284_23# VNB 0.14622f
.ends
