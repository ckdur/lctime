* NGSPICE file created from sky130_as_sc_hs__mux2_4.ext - technology: sky130A

.subckt sky130_as_sc_hs__mux2_4 VPB VPWR VGND S B A Y
R1122 VPB VPWR 0
R1111 VNB VGND 0
X0 Y.t5 a_296_49# VGND.t6 VNB.t7 sky130_fd_pr__nfet_01v8_lvt ad=0.0959 pd=0.965 as=0.0959 ps=0.965 w=0.685 l=0.15
X1 VGND.t0 S.t0 a_27_49# VNB.t0 sky130_fd_pr__nfet_01v8_lvt ad=0.07343 pd=0.775 as=0.11793 ps=1.42 w=0.445 l=0.15
X2 a_206_49# B.t0 VGND.t2 VNB.t3 sky130_fd_pr__nfet_01v8_lvt ad=0.06675 pd=0.745 as=0.07343 ps=0.775 w=0.445 l=0.15
X3 Y.t4 a_296_49# VGND.t4 VNB.t6 sky130_fd_pr__nfet_01v8_lvt ad=0.0959 pd=0.965 as=0.15108 ps=1.155 w=0.685 l=0.15
X4 VGND.t1 A.t0 a_412_49# VNB.t2 sky130_fd_pr__nfet_01v8_lvt ad=0.15108 pd=1.155 as=0.13375 ps=1.095 w=0.595 l=0.15
X5 a_296_49# a_27_49# a_206_375# VPB.t6 sky130_fd_pr__pfet_01v8 ad=0.16643 pd=1.205 as=0.09075 ps=0.905 w=0.605 l=0.15
X6 a_206_375# B.t1 VPWR.t1 VPB.t1 sky130_fd_pr__pfet_01v8 ad=0.09075 pd=0.905 as=0.09983 ps=0.935 w=0.605 l=0.15
X7 Y.t7 a_296_49# VPWR.t5 VPB.t5 sky130_fd_pr__pfet_01v8 ad=0.1099 pd=1.065 as=0.15477 ps=1.255 w=0.785 l=0.15
X8 VPWR.t6 S.t1 a_27_49# VPB.t8 sky130_fd_pr__pfet_01v8 ad=0.09983 pd=0.935 as=0.16033 ps=1.74 w=0.605 l=0.15
X9 VPWR.t0 A.t1 a_446_393# VPB.t0 sky130_fd_pr__pfet_01v8 ad=0.15477 pd=1.255 as=0.08497 ps=0.845 w=0.515 l=0.15
X10 a_446_393# S.t2 a_296_49# VPB.t7 sky130_fd_pr__pfet_01v8 ad=0.08497 pd=0.845 as=0.16643 ps=1.205 w=0.515 l=0.15
X11 VPWR.t4 a_296_49# Y.t6 VPB.t4 sky130_fd_pr__pfet_01v8 ad=0.1099 pd=1.065 as=0.1099 ps=1.065 w=0.785 l=0.15
X12 a_296_49# S.t3 a_206_49# VNB.t1 sky130_fd_pr__nfet_01v8_lvt ad=0.09567 pd=0.875 as=0.06675 ps=0.745 w=0.445 l=0.15
X13 VGND.t3 a_296_49# Y.t3 VNB.t5 sky130_fd_pr__nfet_01v8_lvt ad=0.19865 pd=1.95 as=0.0959 ps=0.965 w=0.685 l=0.15
X14 VGND.t5 a_296_49# Y.t2 VNB.t4 sky130_fd_pr__nfet_01v8_lvt ad=0.0959 pd=0.965 as=0.0959 ps=0.965 w=0.685 l=0.15
X15 Y.t0 a_296_49# VPWR.t3 VPB.t3 sky130_fd_pr__pfet_01v8 ad=0.1099 pd=1.065 as=0.1099 ps=1.065 w=0.785 l=0.15
X16 VPWR.t2 a_296_49# Y.t1 VPB.t2 sky130_fd_pr__pfet_01v8 ad=0.22765 pd=2.15 as=0.1099 ps=1.065 w=0.785 l=0.15
X17 a_412_49# a_27_49# a_296_49# VNB.t8 sky130_fd_pr__nfet_01v8_lvt ad=0.13375 pd=1.095 as=0.09567 ps=0.875 w=0.445 l=0.15
R0 VGND.n1 VGND.n0 208.341
R1 VGND.n10 VGND.n9 185
R2 VGND.n6 VGND.t3 162.709
R3 VGND.n7 VGND.n5 128.642
R4 VGND.n0 VGND.t2 51.2365
R5 VGND.n9 VGND.t1 48.4039
R6 VGND.n9 VGND.t4 42.0815
R7 VGND.n0 VGND.t0 37.7533
R8 VGND.n15 VGND.n3 30.99
R9 VGND.n16 VGND.n15 30.99
R10 VGND.n17 VGND.n16 30.99
R11 VGND.n17 VGND.n1 30.99
R12 VGND.n8 VGND.n7 30.3163
R13 VGND.n5 VGND.t6 24.526
R14 VGND.n5 VGND.t5 24.526
R15 VGND.n11 VGND.n8 23.9567
R16 VGND.n10 VGND.n3 19.3864
R17 VGND.n18 VGND.n17 9.3005
R18 VGND.n16 VGND.n2 9.3005
R19 VGND.n15 VGND.n14 9.3005
R20 VGND.n13 VGND.n3 9.3005
R21 VGND.n12 VGND.n11 9.3005
R22 VGND.n8 VGND.n4 9.3005
R23 VGND.n7 VGND.n6 7.63567
R24 VGND.n19 VGND.n1 7.53867
R25 VGND.n11 VGND.n10 0.8197
R26 VGND.n6 VGND.n4 0.65682
R27 VGND.n19 VGND.n18 0.143203
R28 VGND.n12 VGND.n4 0.120292
R29 VGND.n13 VGND.n12 0.120292
R30 VGND.n14 VGND.n13 0.120292
R31 VGND.n14 VGND.n2 0.120292
R32 VGND.n18 VGND.n2 0.120292
R33 VGND VGND.n19 0.120227
R34 Y.n2 Y.n0 321.488
R35 Y.n5 Y.n3 318.853
R36 Y.n2 Y.n1 223.024
R37 Y.n5 Y.n4 130.148
R38 Y.n0 Y.t1 35.1343
R39 Y.n0 Y.t0 35.1343
R40 Y.n3 Y.t6 35.1343
R41 Y.n3 Y.t7 35.1343
R42 Y.n1 Y.t3 24.526
R43 Y.n1 Y.t5 24.526
R44 Y.n4 Y.t2 24.526
R45 Y.n4 Y.t4 24.526
R46 Y Y.n2 17.0672
R47 Y Y.n5 0.337342
R48 VNB.t8 VNB.t2 1845.16
R49 VNB.t2 VNB.t6 1760
R50 VNB.t1 VNB.t8 1646.45
R51 VNB.t0 VNB.t3 1362.58
R52 VNB.t3 VNB.t1 1277.42
R53 VNB.t7 VNB.t5 1220.65
R54 VNB.t4 VNB.t7 1220.65
R55 VNB.t6 VNB.t4 1220.65
R56 VNB VNB.t0 695.485
R57 S.n0 S.t1 362.036
R58 S S.t2 313.44
R59 S.n1 S.t3 289.103
R60 S S.n0 164.601
R61 S.n0 S.t0 140.316
R62 S S.n1 61.2998
R63 S.n1 S 17.6005
R64 B.n0 B.t0 309.195
R65 B.n0 B.t1 191.73
R66 B B.n0 153.745
R67 A.n0 A.t1 321.952
R68 A.n0 A.t0 162.522
R69 A A.n0 162.339
R70 VPB.t6 VPB.t7 445.312
R71 VPB.t0 VPB.t5 368.125
R72 VPB.t7 VPB.t0 285
R73 VPB.t8 VPB.t1 285
R74 VPB.t1 VPB.t6 267.188
R75 VPB.t3 VPB.t2 255.312
R76 VPB.t4 VPB.t3 255.312
R77 VPB.t5 VPB.t4 255.312
R78 VPB VPB.t8 145.47
R79 VPWR.n7 VPWR.n5 618.883
R80 VPWR.n10 VPWR.n9 609.124
R81 VPWR.n1 VPWR.n0 606.082
R82 VPWR.n6 VPWR.t2 376.993
R83 VPWR.n9 VPWR.t0 109.019
R84 VPWR.n0 VPWR.t1 61.8683
R85 VPWR.n9 VPWR.t5 54.3214
R86 VPWR.n0 VPWR.t6 45.5873
R87 VPWR.n5 VPWR.t3 35.1343
R88 VPWR.n5 VPWR.t4 35.1343
R89 VPWR.n14 VPWR.n3 32.7116
R90 VPWR.n15 VPWR.n14 32.7116
R91 VPWR.n16 VPWR.n15 32.7116
R92 VPWR.n16 VPWR.n1 32.7116
R93 VPWR.n8 VPWR.n7 32.0005
R94 VPWR.n10 VPWR.n3 24.1783
R95 VPWR.n10 VPWR.n8 22.7561
R96 VPWR.n17 VPWR.n16 9.3005
R97 VPWR.n15 VPWR.n2 9.3005
R98 VPWR.n14 VPWR.n13 9.3005
R99 VPWR.n12 VPWR.n3 9.3005
R100 VPWR.n11 VPWR.n10 9.3005
R101 VPWR.n8 VPWR.n4 9.3005
R102 VPWR.n7 VPWR.n6 7.76447
R103 VPWR.n18 VPWR.n1 7.59767
R104 VPWR.n6 VPWR.n4 0.62995
R105 VPWR.n18 VPWR.n17 0.142453
R106 VPWR VPWR.n18 0.120987
R107 VPWR.n11 VPWR.n4 0.120292
R108 VPWR.n12 VPWR.n11 0.120292
R109 VPWR.n13 VPWR.n12 0.120292
R110 VPWR.n13 VPWR.n2 0.120292
R111 VPWR.n17 VPWR.n2 0.120292
C0 VPWR B 0.01572f
C1 a_206_49# a_27_49# 0
C2 a_206_49# VGND 0.00725f
C3 A a_412_49# 0.00122f
C4 a_27_49# VGND 0.06455f
C5 VPWR a_296_49# 0.22931f
C6 Y a_296_49# 0.20304f
C7 A S 0.08795f
C8 a_27_49# VPB 0.11367f
C9 VPWR a_446_393# 0.00548f
C10 VPB VGND 0.01426f
C11 a_27_49# a_412_49# 0
C12 a_412_49# VGND 0.00837f
C13 a_206_49# S 0.00361f
C14 a_27_49# S 0.19916f
C15 a_296_49# A 0.16021f
C16 S VGND 0.08206f
C17 a_206_375# a_296_49# 0.00291f
C18 S VPB 0.12644f
C19 a_446_393# A 0
C20 a_27_49# B 0.16141f
C21 B VGND 0.01535f
C22 a_296_49# a_206_49# 0.003f
C23 a_296_49# a_27_49# 0.03413f
C24 S a_412_49# 0
C25 a_296_49# VGND 0.24595f
C26 B VPB 0.05429f
C27 VPWR Y 0.24953f
C28 a_446_393# a_27_49# 0
C29 a_296_49# VPB 0.2011f
C30 a_446_393# VGND 0
C31 B S 0.19645f
C32 a_296_49# a_412_49# 0.01462f
C33 a_296_49# S 0.13284f
C34 VPWR A 0.01316f
C35 Y A 0
C36 VPWR a_206_375# 0.00723f
C37 a_446_393# S 0
C38 a_296_49# B 0.00324f
C39 VPWR a_206_49# 0
C40 VPWR a_27_49# 0.12504f
C41 Y a_27_49# 0
C42 VPWR VGND 0.11276f
C43 Y VGND 0.23262f
C44 a_296_49# a_446_393# 0.00862f
C45 VPWR VPB 0.12008f
C46 Y VPB 0.01105f
C47 VPWR a_412_49# 0
C48 a_27_49# A 0.02504f
C49 VPWR S 0.03219f
C50 A VGND 0.01775f
C51 a_206_375# a_27_49# 0.0065f
C52 a_206_375# VGND 0
C53 A VPB 0.06937f
C54 VGND VNB 0.62304f
C55 Y VNB 0.05507f
C56 VPWR VNB 0.52417f
C57 A VNB 0.1225f
C58 B VNB 0.09749f
C59 S VNB 0.27142f
C60 VPB VNB 1.04448f
C61 a_296_49# VNB 0.41739f
C62 a_27_49# VNB 0.24069f
.ends
